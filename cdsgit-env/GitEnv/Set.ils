defmethod( SetCG (( ge GitEnv ) setName setValue )

   if( ge->verbose printf("========GitEnv Set============\n"))

   printf(strcat("GitEnv Set: Setting variable " setName " to " setValue " in " ge->user_path "\n"))

   globalValue = GetCG(ge setName ?forcedPath ge->global_path)

   ;Check that the name and values are legal
   line =  strcat(setName " = " setValue)
   envVar = ParseLine(ge line)
   if(!envVar then
      error(strcat("GitEnv Set: Variable " setName " and value " setValue " are not valid!\n"))
   )
   Format(envVar); Format the envVar value for comparason

   if(!globalVar then
      error(strcat("GitEnv Set: Variable " setName " does not exist in the global settings " ge->global_path \
       "\nThe variable must be defined in the global settings to be added to a user's settings"))
   )

   ;Is the user setting the variable to a global? If so it will be removed
   matchedDefault = ( envVar->value == globalValue )

   if( ge->verbose && matchedDefault printf(strcat("GitEnv Set value matched global, removing from user env if it exists\n")))

   foutString = ""; Output string that will be written to file

   envString = OpenCG(ge ge->user_path)
   strList = parseString(envString "\n")

   writeFile = nil
   foundVar = nil

   ;Search each line in the user's setting and check for identical variable name and value
   foreach(line strList
      envVar  = ParseLine(ge line)
      if(envVar then
         varName  = envVar->name
         varValue = envVar->value

         ;Variable name was found, append the line if the values don't match
         if( varName == setName then
            foundVar = t
            writeFile = t
            if( ge->verbose printf(strcat("GitEnv Set found variable in user's settings\n")))
            if(varValue != setValue then
               if( ge->verbose printf(strcat("\tOverwritting mismatched value\n")))
               line =  strcat(setName " = " setValue)
            )
            ;Blank line if the variable value is the global
            if( matchedDefault
               line = ""
            )
         )
      );if

      if(line != ""
         foutString = strcat(foutString line "\n")
      )

   ); foreach

   ;Append the user's file and add the new variable
   if(!foundVar && !matchedDefault then
      if( ge->verbose printf(strcat("GitEnv Set variable not found in user's settings, adding\n")))
      line =  strcat(setName " = " setValue)
      foutString = strcat(foutString line "\n")
      writeFile = t
   )

   if(writeFile then
      if( ge->verbose printf(strcat("GitEnv Set Updates needed, rewriting user's settings\n")))
      Create(ge ?writeString foutString)
   else
      if( ge->verbose printf(strcat("GitEnv Set did not rewrite user's settings\n")))

   )

   ;Return if modifications were made
   writeFile

);
