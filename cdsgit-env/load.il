;GitEnv
;Enviornment variable access/storage

loadi(strcat(cdsgit_ge_path "/GitEnv.ils"))
loadi(strcat(cdsgit_ge_path "/GitEnv/Check.ils"))
loadi(strcat(cdsgit_ge_path "/GitEnv/Create.ils"))
loadi(strcat(cdsgit_ge_path "/GitEnv/GetAll.ils"))
loadi(strcat(cdsgit_ge_path "/GitEnv/Get.ils"))
loadi(strcat(cdsgit_ge_path "/GitEnv/Open.ils"))
loadi(strcat(cdsgit_ge_path "/GitEnv/Parse.ils"))
loadi(strcat(cdsgit_ge_path "/GitEnv/Refresh.ils"))
loadi(strcat(cdsgit_ge_path "/GitEnv/Search.ils"))
loadi(strcat(cdsgit_ge_path "/GitEnv/Set.ils"))
loadi(strcat(cdsgit_ge_path "/GitEnv/SetShell.ils"))

loadi(strcat(cdsgit_ge_path "/GitEnvVar.ils"))
loadi(strcat(cdsgit_ge_path "/GitEnvVar/Format.ils"))
loadi(strcat(cdsgit_ge_path "/GitEnvVar/Bool.ils"))
