loadi(strcat(cdsgit_path "/menus/schematic.menu"))
loadi(strcat(cdsgit_path "/menus/layout.menu"))
loadi(strcat(cdsgit_path "/menus/create_menus.il"))
