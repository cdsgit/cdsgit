load(strcat(cdsgit_path "/forms/CGstatus.ils"))
load(strcat(cdsgit_path "/forms/CGmergeResolve.ils"))
load(strcat(cdsgit_path "/forms/CGstatusAll.ils"))

load(strcat(cdsgit_path "/forms/CGrevSelect/CGrevSelect.il"))
load(strcat(cdsgit_path "/forms/CGrevSelect/CGexport.il"))
load(strcat(cdsgit_path "/forms/CGrevSelect/CGcheckout.il"))

;Branching Forms
load(strcat(cdsgit_path "/forms/CGbranchSelect/CGbranchSelect.ils"))
load(strcat(cdsgit_path "/forms/CGbranchSelect/CGBSmerge.ils"))
load(strcat(cdsgit_path "/forms/CGbranchSelect/CGBSbranchops.ils"))

load(strcat(cdsgit_path "/forms/CGclone.ils"))
load(strcat(cdsgit_path "/forms/CGsetupSSH.ils"))

load(strcat(cdsgit_path "/forms/CGpathBrowse/CGpathBrowse.ils"))
load(strcat(cdsgit_path "/forms/CGpathBrowse/CGPBinit.ils"))

load(strcat(cdsgit_path "/forms/CGlibSelect.il"))

/*
Archived
Commit form is removed, use status form
load(strcat(cdsgit_path "/forms/CGcommit.ils"))

*/
