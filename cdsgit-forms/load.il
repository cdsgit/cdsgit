/*

*/

cdsgitform_path = strcat(cdsgit_path "/cdsgit-forms")

/* TODO GF2 is not used
loadi(strcat(cdsgitform_path "/GenericForm2/GenericForm2.ils"))
loadi(strcat(cdsgitform_path "/GenericForm2/form_functions.ils"))
loadi(strcat(cdsgitform_path "/GenericForm2/db_functions.ils"))
loadi(strcat(cdsgitform_path "/GenericForm2/disp_functions.ils"))
*/

loadi(strcat(cdsgitform_path "/Gridder/Gridder.ils"))
