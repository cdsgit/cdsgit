/*
   Bindkeys
load("/home/acook/git/cdsgit/cdsgit-binder/binder_test.ils")
*/

load("/home/acook/git/cdsgit/cdsgit-binder/Binder.ils")

myBindkeys = list(

   list("Schematics" "a" "myCB()" "CoolApp" "A dumb bindkey a")
   list("Schematics" "b" "myCB1()" "CoolApp" "A dumb bindkey b")

)

bk = Binder(?verbose t)

AddCG(bk myBindkeys)

Bind(bk)
