;schRegPostCheckTrigger('CGcheckTrigger)

load(strcat(cdsgit_path "/triggers/CGsaveTrigger.il"))

dbRegPostSaveTrigger('CGsaveTrigger)
